** sch_path: /home/uchida/work/design/TR1nm/sch/DFFS_uchi.sch
.subckt DFFS_uchi D CK SET QB Q VDD GND
*.ipin D
*.ipin CK
*.ipin SET
*.opin QB
*.opin Q
XMP1 net1 CK VDD VDD PMOS w=10.2u l=1u as=2.856e-11 ad=2.856e-11 ps=2.6e-05 pd=2.6e-05
XMN1 net1 CK GND GND NMOS w=3.4u l=1u as=9.52e-12 ad=9.52e-12 ps=1.24e-05 pd=1.24e-05
XMP2 CKP net1 VDD VDD PMOS w=10.2u l=1u as=2.856e-11 ad=2.856e-11 ps=2.6e-05 pd=2.6e-05
XMN2 CKP net1 GND GND NMOS w=3.4u l=1u as=9.52e-12 ad=9.52e-12 ps=1.24e-05 pd=1.24e-05
XMP3 CKB CKP VDD VDD PMOS w=10.2u l=1u as=2.856e-11 ad=2.856e-11 ps=2.6e-05 pd=2.6e-05
XMN3 CKB CKP GND GND NMOS w=3.4u l=1u as=9.52e-12 ad=9.52e-12 ps=1.24e-05 pd=1.24e-05
XMP4 net2 D VDD VDD PMOS w=10.2u l=1u as=2.856e-11 ad=2.856e-11 ps=2.6e-05 pd=2.6e-05
XMP5 ml_ax CKP net2 VDD PMOS w=10.2u l=1u as=2.856e-11 ad=2.856e-11 ps=2.6e-05 pd=2.6e-05
XMN4 ml_ax CKB net3 GND NMOS w=3.4u l=1u as=9.52e-12 ad=9.52e-12 ps=1.24e-05 pd=1.24e-05
XMN5 net3 D GND GND NMOS w=3.4u l=1u as=9.52e-12 ad=9.52e-12 ps=1.24e-05 pd=1.24e-05
XMP6 ml_b ml_ax VDD VDD PMOS w=10.2u l=1u as=2.856e-11 ad=2.856e-11 ps=2.6e-05 pd=2.6e-05
XMP7 ml_b SET VDD VDD PMOS w=10.2u l=1u as=2.856e-11 ad=2.856e-11 ps=2.6e-05 pd=2.6e-05
XMN6 ml_b SET net4 GND NMOS w=3.4u l=1u as=9.52e-12 ad=9.52e-12 ps=1.24e-05 pd=1.24e-05
XMN7 net4 ml_ax GND GND NMOS w=3.4u l=1u as=9.52e-12 ad=9.52e-12 ps=1.24e-05 pd=1.24e-05
XMP8 net5 ml_b VDD VDD PMOS w=10.2u l=1u as=2.856e-11 ad=2.856e-11 ps=2.6e-05 pd=2.6e-05
XMP9 ml_ax CKB net5 VDD PMOS w=10.2u l=1u as=2.856e-11 ad=2.856e-11 ps=2.6e-05 pd=2.6e-05
XMN8 ml_ax CKP net6 GND NMOS w=3.4u l=1u as=9.52e-12 ad=9.52e-12 ps=1.24e-05 pd=1.24e-05
XMN9 net6 ml_b GND GND NMOS w=3.4u l=1u as=9.52e-12 ad=9.52e-12 ps=1.24e-05 pd=1.24e-05
XMP10 net7 ml_b VDD VDD PMOS w=10.2u l=1u as=2.856e-11 ad=2.856e-11 ps=2.6e-05 pd=2.6e-05
XMP11 sl_ax CKB net7 VDD PMOS w=10.2u l=1u as=2.856e-11 ad=2.856e-11 ps=2.6e-05 pd=2.6e-05
XMN10 sl_ax CKP net8 GND NMOS w=3.4u l=1u as=9.52e-12 ad=9.52e-12 ps=1.24e-05 pd=1.24e-05
XMN11 net8 ml_b GND GND NMOS w=3.4u l=1u as=9.52e-12 ad=9.52e-12 ps=1.24e-05 pd=1.24e-05
XMP12 sl_b sl_ax VDD VDD PMOS w=10.2u l=1u as=2.856e-11 ad=2.856e-11 ps=2.6e-05 pd=2.6e-05
XMP13 sl_b SET VDD VDD PMOS w=10.2u l=1u as=2.856e-11 ad=2.856e-11 ps=2.6e-05 pd=2.6e-05
XMN12 sl_b SET net9 GND NMOS w=3.4u l=1u as=9.52e-12 ad=9.52e-12 ps=1.24e-05 pd=1.24e-05
XMN13 net9 sl_ax GND GND NMOS w=3.4u l=1u as=9.52e-12 ad=9.52e-12 ps=1.24e-05 pd=1.24e-05
XMP14 net10 sl_b VDD VDD PMOS w=10.2u l=1u as=2.856e-11 ad=2.856e-11 ps=2.6e-05 pd=2.6e-05
XMP15 sl_ax CKP net10 VDD PMOS w=10.2u l=1u as=2.856e-11 ad=2.856e-11 ps=2.6e-05 pd=2.6e-05
XMN14 sl_ax CKB net11 GND NMOS w=3.4u l=1u as=9.52e-12 ad=9.52e-12 ps=1.24e-05 pd=1.24e-05
XMN15 net11 sl_b GND GND NMOS w=3.4u l=1u as=9.52e-12 ad=9.52e-12 ps=1.24e-05 pd=1.24e-05
XMP16 QB sl_b VDD VDD PMOS w=10.2u l=1u as=2.856e-11 ad=2.856e-11 ps=2.6e-05 pd=2.6e-05
XMN16 QB sl_b GND GND NMOS w=3.4u l=1u as=9.52e-12 ad=9.52e-12 ps=1.24e-05 pd=1.24e-05
XMP17 Q QB VDD VDD PMOS w=10.2u l=1u as=2.856e-11 ad=2.856e-11 ps=2.6e-05 pd=2.6e-05
XMN17 Q QB GND GND NMOS w=3.4u l=1u as=9.52e-12 ad=9.52e-12 ps=1.24e-05 pd=1.24e-05
.ends
***.GLOBAL VDD
***.GLOBAL GND
